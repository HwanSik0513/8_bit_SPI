// giolib045/PADANALOG/schematic

simulator lang=spectre

subckt PADANALOG AY VSS VDDIOR! VDD VSSIOR!
M4 (AY VSSIOR! VSSIOR! VSSIOR!) g45n2svt w=(560u) l=200n nf=56 m=(1)
ends PADANALOG

// giolib045/BONDPAD52/schematic
subckt BONDPAD52 PAD
ends BONDPAD52

// giolib045/levelup_latch/schematic
subckt levelup_latch nmos nmos25 pmos pmos25 inh_VDD inh_VDDIOR inh_VSS inh_VSSIOR
    PM4 (net0189 nmos inh_VDD inh_VDD) g45p1svt w=(4u) l=45n nf=2 m=(1)
    PM3 (net0218 net0189 inh_VDD inh_VDD) g45p1svt w=(4u) l=45n nf=2 m=(1)
    PM2 (net0227 net59 inh_VDD inh_VDD) g45p1svt w=(4u) l=45n nf=2 m=(1)
    PM1 (net59 pmos inh_VDD inh_VDD) g45p1svt w=(4u) l=45n nf=2 m=(1)
    M15 (net093 net0174 inh_VSSIOR inh_VSSIOR) g45n2svt w=(500n) l=150n nf=1 m=(1)
    M11 (net0174 net093 inh_VSSIOR inh_VSSIOR) g45n2svt w=(500n) l=150n nf=1 m=(1)
    M21 (pmos25 net0174 inh_VSSIOR inh_VSSIOR) g45n2svt w=(5u) l=150n nf=2 m=(1)
    M19 (net0110 net0106 inh_VSSIOR inh_VSSIOR) g45n2svt w=(500n) l=150n nf=1 m=(1)
    M20 (net0106 net0110 inh_VSSIOR inh_VSSIOR) g45n2svt w=(500n) l=150n nf=1 m=(1)
    M26 (pmos25 net0174 inh_VSSIOR inh_VSSIOR) g45n2svt w=(5u) l=150n nf=2 m=(1)
    M23 (nmos25 net0110 inh_VSSIOR inh_VSSIOR) g45n2svt w=(5u) l=150n nf=2 m=(1)
    M27 (pmos25 net0174 inh_VSSIOR inh_VSSIOR) g45n2svt w=(5u) l=150n nf=2 m=(1)
    M30 (nmos25 net0110 inh_VSSIOR inh_VSSIOR) g45n2svt w=(5u) l=150n nf=2 m=(1)
    NM4 (net0218 net0189 inh_VSS inh_VSS) g45n1svt w=(2u) l=45n nf=1 m=(1)
    NM6 (net093 net59 inh_VSS inh_VSS) g45n1svt w=(5u) l=45n nf=2 m=(1)
    NM1 (net59 pmos inh_VSS inh_VSS) g45n1svt w=(2u) l=45n nf=1 m=(1)
    NM2 (net0227 net59 inh_VSS inh_VSS) g45n1svt w=(2u) l=45n nf=1 m=(1)
    NM7 (net0106 net0189 inh_VSS inh_VSS) g45n1svt w=(5u) l=45n nf=2 m=(1)
    NM5 (net0174 net0227 inh_VSS inh_VSS) g45n1svt w=(5u) l=45n nf=2 m=(1)
    NM8 (net0110 net0218 inh_VSS inh_VSS) g45n1svt w=(5u) l=45n nf=2 m=(1)
    NM3 (net0189 nmos inh_VSS inh_VSS) g45n1svt w=(2u) l=45n nf=1 m=(1)
    M14 (net0174 net093 inh_VDDIOR inh_VDDIOR) g45p2svt w=(4u) l=150n nf=2 m=(1)
    M18 (net093 net0174 inh_VDDIOR inh_VDDIOR) g45p2svt w=(4u) l=150n nf=2 m=(1)
    M24 (net0110 net0106 inh_VDDIOR inh_VDDIOR) g45p2svt w=(5u) l=150n nf=2 m=(1)
    M22 (net0106 net0110 inh_VDDIOR inh_VDDIOR) g45p2svt w=(5u) l=150n nf=2 m=(1)
    M13 (nmos25 net0110 inh_VDDIOR inh_VDDIOR) g45p2svt w=(5u) l=150n nf=2 m=(1)
    M12 (pmos25 net0174 inh_VDDIOR inh_VDDIOR) g45p2svt w=(4u) l=150n nf=2 m=(1)
    M29 (nmos25 net0110 inh_VDDIOR inh_VDDIOR) g45p2svt w=(5u) l=150n nf=2 m=(1)
    M28 (nmos25 net0110 inh_VDDIOR inh_VDDIOR) g45p2svt w=(5u) l=150n nf=2 m=(1)
    M31 (pmos25 net0174 inh_VDDIOR inh_VDDIOR) g45p2svt w=(4u) l=150n nf=2 m=(1)
ends levelup_latch

// giolib045/bidirlogic/schematic
subckt bidirlogic A NMOS OEN PMOS inh_VDD inh_VSS
    NM0 (OE OEN inh_VSS inh_VSS) g45n1svt w=(500n) l=45n nf=1 m=(1)
    NM4 (NMOS OEB inh_VSS inh_VSS) g45n1svt w=(500n) l=45n nf=1 m=(1)
    NM2 (OEB OE inh_VSS inh_VSS) g45n1svt w=(500n) l=45n nf=1 m=(1)
    NM3 (NMOS A inh_VSS inh_VSS) g45n1svt w=(500n) l=45n nf=1 m=(1)
    NM5 (PMOS OE NMOS inh_VSS) g45n1svt w=(500n) l=45n nf=1 m=(1)
    PM1 (OE OEN inh_VDD inh_VDD) g45p1svt w=(1u) l=45n nf=1 m=(1)
    PM2 (OEB OE inh_VDD inh_VDD) g45p1svt w=(1u) l=45n nf=1 m=(1)
    PM3 (PMOS A inh_VDD inh_VDD) g45p1svt w=(1u) l=45n nf=1 m=(1)
    PM4 (NMOS OEB PMOS inh_VDD) g45p1svt w=(1u) l=45n nf=1 m=(1)
    PM5 (PMOS OE inh_VDD inh_VDD) g45p1svt w=(1u) l=45n nf=1 m=(1)
ends bidirlogic

// giolib045/ESDCore04/schematic
subckt ESDCore04 NMos PAD PMos inh_VDD inh_VDDIOR inh_VSS inh_VSSIOR
    M8 (PAD NMos inh_VSSIOR inh_VSSIOR) g45n2svt w=(80u) l=200n nf=8 m=(1)
    M4 (PAD inh_VSSIOR inh_VSSIOR inh_VSSIOR) g45n2svt w=(480u) l=200n nf=48 m=(1)
    M9 (PAD PMos inh_VDDIOR inh_VDDIOR) g45p2svt w=(160u) l=200n nf=16 m=(1)
    M6 (PAD inh_VDDIOR inh_VDDIOR inh_VDDIOR) g45p2svt w=(400u) l=200n nf=40 m=(1)
ends ESDCore04

// giolib045/inputlogic/schematic
subckt inputlogic Y PAD inh_VDD inh_VSS
    M2 (net026 PAD inh_VSS inh_VSS) g45n2svt w=(4u) l=150n nf=2 m=(1)
    M0 (net026 PAD inh_VSS inh_VSS) g45n2svt w=(4u) l=150n nf=2 m=(1)
    NM0 (Y net026 inh_VSS inh_VSS) g45n1svt w=(5u) l=45n nf=2 m=(1)
    PM1 (Y net026 inh_VDD inh_VDD) g45p1svt w=(4u) l=45n nf=2 m=(1)
    M5 (net026 PAD inh_VDD inh_VDD) g45p2svt w=(5u) l=150n nf=2 m=(1)
    M4 (net026 PAD inh_VDD inh_VDD) g45p2svt w=(5u) l=150n nf=2 m=(1)
    M3 (net026 PAD inh_VDD inh_VDD) g45p2svt w=(5u) l=150n nf=2 m=(1)
    M1 (net026 PAD inh_VDD inh_VDD) g45p2svt w=(5u) l=150n nf=2 m=(1)
ends inputlogic

// giolib045/IORINGDB/schematic
subckt IORINGDB A OEN PAD Y inh_VDD inh_VDDIOR inh_VSS inh_VSSIOR
    I2 (nmos nmos25 pmos pmos25 inh_VDD inh_VDDIOR inh_VSS inh_VSSIOR) levelup_latch
    I1 (A nmos OEN pmos inh_VDD inh_VSS) bidirlogic
    I3 (nmos25 PAD pmos25 inh_VDD inh_VDDIOR inh_VSS inh_VSSIOR) ESDCore04
    I4 (Y PAD inh_VDD inh_VSS) inputlogic
ends IORINGDB
// giolib045/PADDB/schematic

simulator lang=spectre

subckt PADDB A OEN PAD Y VSSIOR! VSS VDDIOR! VDD
I18 (PAD) BONDPAD52
I17 (A OEN PAD Y VDD VDDIOR! VSS VSSIOR!) IORINGDB
ends PADDB

// giolib045/BONDPAD52/schematic
subckt BONDPAD52 PAD
ends BONDPAD52

// giolib045/inputlogic/schematic
subckt inputlogic Y PAD inh_VDD inh_VSS
    M2 (net026 PAD inh_VSS inh_VSS) g45n2svt w=(4u) l=150n nf=2 m=(1)
    M0 (net026 PAD inh_VSS inh_VSS) g45n2svt w=(4u) l=150n nf=2 m=(1)
    NM0 (Y net026 inh_VSS inh_VSS) g45n1svt w=(5u) l=45n nf=2 m=(1)
    PM1 (Y net026 inh_VDD inh_VDD) g45p1svt w=(4u) l=45n nf=2 m=(1)
    M5 (net026 PAD inh_VDD inh_VDD) g45p2svt w=(5u) l=150n nf=2 m=(1)
    M4 (net026 PAD inh_VDD inh_VDD) g45p2svt w=(5u) l=150n nf=2 m=(1)
    M3 (net026 PAD inh_VDD inh_VDD) g45p2svt w=(5u) l=150n nf=2 m=(1)
    M1 (net026 PAD inh_VDD inh_VDD) g45p2svt w=(5u) l=150n nf=2 m=(1)
ends inputlogic

// giolib045/ESDCore04_Input/schematic
subckt ESDCore04_Input PAD inh_VDD inh_VDDIOR inh_VSS inh_VSSIOR
    M4 (PAD inh_VSSIOR inh_VSSIOR inh_VSSIOR) g45n2svt w=(560u) l=200n nf=56 m=(1)
    M6 (PAD inh_VDDIOR inh_VDDIOR inh_VDDIOR) g45p2svt w=(560u) l=200n nf=56 m=(1)
ends ESDCore04_Input

// giolib045/IORINGDI/schematic
subckt IORINGDI PAD Y inh_VDD inh_VDDIOR inh_VSS inh_VSSIOR
    I2 (Y PAD inh_VDD inh_VSS) inputlogic
    I1 (PAD inh_VDD inh_VDDIOR inh_VSS inh_VSSIOR) ESDCore04_Input
ends IORINGDI
// giolib045/PADDI/schematic

simulator lang=spectre

subckt PADDI PAD Y VSSIOR! VDD VDDIOR! VSS
I2 (PAD) BONDPAD52
I1 (PAD Y VDD VDDIOR! VSS VSSIOR!) IORINGDI
ends PADDI

// giolib045/BONDPAD52/schematic
subckt BONDPAD52 PAD
ends BONDPAD52

// giolib045/levelup_latch/schematic
subckt levelup_latch nmos nmos25 pmos pmos25 inh_VDD inh_VDDIOR inh_VSS inh_VSSIOR
    PM4 (net0189 nmos inh_VDD inh_VDD) g45p1svt w=(4u) l=45n nf=2 m=(1)
    PM3 (net0218 net0189 inh_VDD inh_VDD) g45p1svt w=(4u) l=45n nf=2 m=(1)
    PM2 (net0227 net59 inh_VDD inh_VDD) g45p1svt w=(4u) l=45n nf=2 m=(1)
    PM1 (net59 pmos inh_VDD inh_VDD) g45p1svt w=(4u) l=45n nf=2 m=(1)
    M15 (net093 net0174 inh_VSSIOR inh_VSSIOR) g45n2svt w=(500n) l=150n nf=1 m=(1)
    M11 (net0174 net093 inh_VSSIOR inh_VSSIOR) g45n2svt w=(500n) l=150n nf=1 m=(1)
    M21 (pmos25 net0174 inh_VSSIOR inh_VSSIOR) g45n2svt w=(5u) l=150n nf=2 m=(1)
    M19 (net0110 net0106 inh_VSSIOR inh_VSSIOR) g45n2svt w=(500n) l=150n nf=1 m=(1)
    M20 (net0106 net0110 inh_VSSIOR inh_VSSIOR) g45n2svt w=(500n) l=150n nf=1 m=(1)
    M26 (pmos25 net0174 inh_VSSIOR inh_VSSIOR) g45n2svt w=(5u) l=150n nf=2 m=(1)
    M23 (nmos25 net0110 inh_VSSIOR inh_VSSIOR) g45n2svt w=(5u) l=150n nf=2 m=(1)
    M27 (pmos25 net0174 inh_VSSIOR inh_VSSIOR) g45n2svt w=(5u) l=150n nf=2 m=(1)
    M30 (nmos25 net0110 inh_VSSIOR inh_VSSIOR) g45n2svt w=(5u) l=150n nf=2 m=(1)
    NM4 (net0218 net0189 inh_VSS inh_VSS) g45n1svt w=(2u) l=45n nf=1 m=(1)
    NM6 (net093 net59 inh_VSS inh_VSS) g45n1svt w=(5u) l=45n nf=2 m=(1)
    NM1 (net59 pmos inh_VSS inh_VSS) g45n1svt w=(2u) l=45n nf=1 m=(1)
    NM2 (net0227 net59 inh_VSS inh_VSS) g45n1svt w=(2u) l=45n nf=1 m=(1)
    NM7 (net0106 net0189 inh_VSS inh_VSS) g45n1svt w=(5u) l=45n nf=2 m=(1)
    NM5 (net0174 net0227 inh_VSS inh_VSS) g45n1svt w=(5u) l=45n nf=2 m=(1)
    NM8 (net0110 net0218 inh_VSS inh_VSS) g45n1svt w=(5u) l=45n nf=2 m=(1)
    NM3 (net0189 nmos inh_VSS inh_VSS) g45n1svt w=(2u) l=45n nf=1 m=(1)
    M14 (net0174 net093 inh_VDDIOR inh_VDDIOR) g45p2svt w=(4u) l=150n nf=2 m=(1)
    M18 (net093 net0174 inh_VDDIOR inh_VDDIOR) g45p2svt w=(4u) l=150n nf=2 m=(1)
    M24 (net0110 net0106 inh_VDDIOR inh_VDDIOR) g45p2svt w=(5u) l=150n nf=2 m=(1)
    M22 (net0106 net0110 inh_VDDIOR inh_VDDIOR) g45p2svt w=(5u) l=150n nf=2 m=(1)
    M13 (nmos25 net0110 inh_VDDIOR inh_VDDIOR) g45p2svt w=(5u) l=150n nf=2 m=(1)
    M12 (pmos25 net0174 inh_VDDIOR inh_VDDIOR) g45p2svt w=(4u) l=150n nf=2 m=(1)
    M29 (nmos25 net0110 inh_VDDIOR inh_VDDIOR) g45p2svt w=(5u) l=150n nf=2 m=(1)
    M28 (nmos25 net0110 inh_VDDIOR inh_VDDIOR) g45p2svt w=(5u) l=150n nf=2 m=(1)
    M31 (pmos25 net0174 inh_VDDIOR inh_VDDIOR) g45p2svt w=(4u) l=150n nf=2 m=(1)
ends levelup_latch

// giolib045/ESDCore04/schematic
subckt ESDCore04 NMos PAD PMos inh_VDD inh_VDDIOR inh_VSS inh_VSSIOR
    M8 (PAD NMos inh_VSSIOR inh_VSSIOR) g45n2svt w=(80u) l=200n nf=8 m=(1)
    M4 (PAD inh_VSSIOR inh_VSSIOR inh_VSSIOR) g45n2svt w=(480u) l=200n nf=48 m=(1)
    M9 (PAD PMos inh_VDDIOR inh_VDDIOR) g45p2svt w=(160u) l=200n nf=16 m=(1)
    M6 (PAD inh_VDDIOR inh_VDDIOR inh_VDDIOR) g45p2svt w=(400u) l=200n nf=40 m=(1)
ends ESDCore04

// giolib045/nonzoutlogic/schematic
subckt nonzoutlogic A NMOS PMOS inh_VDD inh_VSS
    NM0 (net79 net79 inh_VSS inh_VSS) g45n1svt w=(500n) l=45n nf=1 m=(1)
    NM4 (NMOS OEB inh_VSS inh_VSS) g45n1svt w=(500n) l=45n nf=1 m=(1)
    NM2 (OEB OE inh_VSS inh_VSS) g45n1svt w=(500n) l=45n nf=1 m=(1)
    NM3 (NMOS A inh_VSS inh_VSS) g45n1svt w=(500n) l=45n nf=1 m=(1)
    NM5 (PMOS OE NMOS inh_VSS) g45n1svt w=(500n) l=45n nf=1 m=(1)
    PM1 (OE net79 inh_VDD inh_VDD) g45p1svt w=(1u) l=45n nf=1 m=(1)
    PM2 (OEB OE inh_VDD inh_VDD) g45p1svt w=(1u) l=45n nf=1 m=(1)
    PM3 (PMOS A inh_VDD inh_VDD) g45p1svt w=(1u) l=45n nf=1 m=(1)
    PM4 (NMOS OEB PMOS inh_VDD) g45p1svt w=(1u) l=45n nf=1 m=(1)
    PM5 (PMOS OE inh_VDD inh_VDD) g45p1svt w=(1u) l=45n nf=1 m=(1)
ends nonzoutlogic

// giolib045/IORINGDO/schematic
subckt IORINGDO A PAD inh_VDD inh_VDDIOR inh_VSS inh_VSSIOR
    I2 (nmos nmos25 pmos pmos25 inh_VDD inh_VDDIOR inh_VSS inh_VSSIOR) levelup_latch
    I3 (nmos25 PAD pmos25 inh_VDD inh_VDDIOR inh_VSS inh_VSSIOR) ESDCore04
    I1 (A nmos pmos inh_VDD inh_VSS) nonzoutlogic
ends IORINGDO
// giolib045/PADDO/schematic

simulator lang=spectre

subckt PADDO A PAD VDD VDDIOR! VSS VSSIOR!
I2 (PAD) BONDPAD52
I1 (A PAD VDD VDDIOR! VSS VSSIOR!) IORINGDO
ends PADDO

// giolib045/BONDPAD52/schematic
subckt BONDPAD52 PAD
ends BONDPAD52

// giolib045/levelup_latch/schematic
subckt levelup_latch nmos nmos25 pmos pmos25 inh_VDD inh_VDDIOR inh_VSS inh_VSSIOR
    PM4 (net0189 nmos inh_VDD inh_VDD) g45p1svt w=(4u) l=45n nf=2 m=(1)
    PM3 (net0218 net0189 inh_VDD inh_VDD) g45p1svt w=(4u) l=45n nf=2 m=(1)
    PM2 (net0227 net59 inh_VDD inh_VDD) g45p1svt w=(4u) l=45n nf=2 m=(1)
    PM1 (net59 pmos inh_VDD inh_VDD) g45p1svt w=(4u) l=45n nf=2 m=(1)
    M15 (net093 net0174 inh_VSSIOR inh_VSSIOR) g45n2svt w=(500n) l=150n nf=1 m=(1)
    M11 (net0174 net093 inh_VSSIOR inh_VSSIOR) g45n2svt w=(500n) l=150n nf=1 m=(1)
    M21 (pmos25 net0174 inh_VSSIOR inh_VSSIOR) g45n2svt w=(5u) l=150n nf=2 m=(1)
    M19 (net0110 net0106 inh_VSSIOR inh_VSSIOR) g45n2svt w=(500n) l=150n nf=1 m=(1)
    M20 (net0106 net0110 inh_VSSIOR inh_VSSIOR) g45n2svt w=(500n) l=150n nf=1 m=(1)
    M26 (pmos25 net0174 inh_VSSIOR inh_VSSIOR) g45n2svt w=(5u) l=150n nf=2 m=(1)
    M23 (nmos25 net0110 inh_VSSIOR inh_VSSIOR) g45n2svt w=(5u) l=150n nf=2 m=(1)
    M27 (pmos25 net0174 inh_VSSIOR inh_VSSIOR) g45n2svt w=(5u) l=150n nf=2 m=(1)
    M30 (nmos25 net0110 inh_VSSIOR inh_VSSIOR) g45n2svt w=(5u) l=150n nf=2 m=(1)
    NM4 (net0218 net0189 inh_VSS inh_VSS) g45n1svt w=(2u) l=45n nf=1 m=(1)
    NM6 (net093 net59 inh_VSS inh_VSS) g45n1svt w=(5u) l=45n nf=2 m=(1)
    NM1 (net59 pmos inh_VSS inh_VSS) g45n1svt w=(2u) l=45n nf=1 m=(1)
    NM2 (net0227 net59 inh_VSS inh_VSS) g45n1svt w=(2u) l=45n nf=1 m=(1)
    NM7 (net0106 net0189 inh_VSS inh_VSS) g45n1svt w=(5u) l=45n nf=2 m=(1)
    NM5 (net0174 net0227 inh_VSS inh_VSS) g45n1svt w=(5u) l=45n nf=2 m=(1)
    NM8 (net0110 net0218 inh_VSS inh_VSS) g45n1svt w=(5u) l=45n nf=2 m=(1)
    NM3 (net0189 nmos inh_VSS inh_VSS) g45n1svt w=(2u) l=45n nf=1 m=(1)
    M14 (net0174 net093 inh_VDDIOR inh_VDDIOR) g45p2svt w=(4u) l=150n nf=2 m=(1)
    M18 (net093 net0174 inh_VDDIOR inh_VDDIOR) g45p2svt w=(4u) l=150n nf=2 m=(1)
    M24 (net0110 net0106 inh_VDDIOR inh_VDDIOR) g45p2svt w=(5u) l=150n nf=2 m=(1)
    M22 (net0106 net0110 inh_VDDIOR inh_VDDIOR) g45p2svt w=(5u) l=150n nf=2 m=(1)
    M13 (nmos25 net0110 inh_VDDIOR inh_VDDIOR) g45p2svt w=(5u) l=150n nf=2 m=(1)
    M12 (pmos25 net0174 inh_VDDIOR inh_VDDIOR) g45p2svt w=(4u) l=150n nf=2 m=(1)
    M29 (nmos25 net0110 inh_VDDIOR inh_VDDIOR) g45p2svt w=(5u) l=150n nf=2 m=(1)
    M28 (nmos25 net0110 inh_VDDIOR inh_VDDIOR) g45p2svt w=(5u) l=150n nf=2 m=(1)
    M31 (pmos25 net0174 inh_VDDIOR inh_VDDIOR) g45p2svt w=(4u) l=150n nf=2 m=(1)
ends levelup_latch

// giolib045/ESDCore04/schematic
subckt ESDCore04 NMos PAD PMos inh_VDD inh_VDDIOR inh_VSS inh_VSSIOR
    M8 (PAD NMos inh_VSSIOR inh_VSSIOR) g45n2svt w=(80u) l=200n nf=8 m=(1)
    M4 (PAD inh_VSSIOR inh_VSSIOR inh_VSSIOR) g45n2svt w=(480u) l=200n nf=48 m=(1)
    M9 (PAD PMos inh_VDDIOR inh_VDDIOR) g45p2svt w=(160u) l=200n nf=16 m=(1)
    M6 (PAD inh_VDDIOR inh_VDDIOR inh_VDDIOR) g45p2svt w=(400u) l=200n nf=40 m=(1)
ends ESDCore04

// giolib045/bidirlogic/schematic
subckt bidirlogic A NMOS OEN PMOS inh_VDD inh_VSS
    NM0 (OE OEN inh_VSS inh_VSS) g45n1svt w=(500n) l=45n nf=1 m=(1)
    NM4 (NMOS OEB inh_VSS inh_VSS) g45n1svt w=(500n) l=45n nf=1 m=(1)
    NM2 (OEB OE inh_VSS inh_VSS) g45n1svt w=(500n) l=45n nf=1 m=(1)
    NM3 (NMOS A inh_VSS inh_VSS) g45n1svt w=(500n) l=45n nf=1 m=(1)
    NM5 (PMOS OE NMOS inh_VSS) g45n1svt w=(500n) l=45n nf=1 m=(1)
    PM1 (OE OEN inh_VDD inh_VDD) g45p1svt w=(1u) l=45n nf=1 m=(1)
    PM2 (OEB OE inh_VDD inh_VDD) g45p1svt w=(1u) l=45n nf=1 m=(1)
    PM3 (PMOS A inh_VDD inh_VDD) g45p1svt w=(1u) l=45n nf=1 m=(1)
    PM4 (NMOS OEB PMOS inh_VDD) g45p1svt w=(1u) l=45n nf=1 m=(1)
    PM5 (PMOS OE inh_VDD inh_VDD) g45p1svt w=(1u) l=45n nf=1 m=(1)
ends bidirlogic

// giolib045/IORINGDOZ/schematic
subckt IORINGDOZ A OEN PAD inh_VDD inh_VDDIOR inh_VSS inh_VSSIOR
    I2 (nmos nmos25 pmos pmos25 inh_VDD inh_VDDIOR inh_VSS inh_VSSIOR) levelup_latch
    I3 (nmos25 PAD pmos25 inh_VDD inh_VDDIOR inh_VSS inh_VSSIOR) ESDCore04
    I1 (A nmos OEN pmos inh_VDD inh_VSS) bidirlogic
ends IORINGDOZ
// giolib045/PADDOZ/schematic

simulator lang=spectre

subckt PADDOZ A OEN PAD VSS VDDIOR! VDD VSSIOR!
I2 (PAD) BONDPAD52
I14 (A OEN PAD VDD VDDIOR! VSS VSSIOR!) IORINGDOZ
ends PADDOZ

// giolib045/BONDPAD52/schematic
subckt BONDPAD52 PAD
ends BONDPAD52

// giolib045/IORINGVDD/schematic
subckt IORINGVDD inh_VDD inh_VDDIOR inh_VSS inh_VSSIOR
    M4 (inh_VDD inh_VSSIOR inh_VSSIOR inh_VSSIOR) g45n2svt w=(560u) l=200n nf=56 m=(1)
ends IORINGVDD
// giolib045/PADVDD/schematic

simulator lang=spectre

subckt PADVDD VDD VDDIOR! VSSIOR! VSS
I2 (VDD) BONDPAD52
I1 (VDD VDDIOR! VSS VSSIOR!) IORINGVDD
ends PADVDD

// giolib045/IORINGVDD25/schematic
subckt IORINGVDD25 inh_VDD inh_VDD25 inh_VDDIOR inh_VSS inh_VSSIOR
    M4 (inh_VDD25 inh_VSSIOR inh_VSSIOR inh_VSSIOR) g45n2svt w=(560u) l=200n nf=56 m=(1)
ends IORINGVDD25

// giolib045/BONDPAD52/schematic
subckt BONDPAD52 PAD
ends BONDPAD52
// giolib045/PADVDD25/schematic

simulator lang=spectre

subckt PADVDD25 VDDIOR! VDD25! VSSIOR! VSS VDD
I1 (VDD VDD25! VDDIOR! VSS VSSIOR!) IORINGVDD25
I2 (VDD25!) BONDPAD52
ends PADVDD25

// giolib045/BONDPAD52/schematic
subckt BONDPAD52 PAD
ends BONDPAD52

// giolib045/IORINGVDDIOR/schematic
subckt IORINGVDDIOR inh_VDD inh_VDDIOR inh_VSS inh_VSSIOR
    M4 (inh_VDDIOR inh_VSSIOR inh_VSSIOR inh_VSSIOR) g45n2svt w=(560u) l=200n nf=56 m=(1)
ends IORINGVDDIOR
// giolib045/PADVDDIOR/schematic

simulator lang=spectre

subckt PADVDDIOR VDDIOR! VSSIOR! VDD VSS
I2 (VDDIOR!) BONDPAD52
I0 (VDD VDDIOR! VSS VSSIOR!) IORINGVDDIOR
ends PADVDDIOR

// giolib045/IORINGVSS/schematic
subckt IORINGVSS inh_VDD inh_VDDIOR inh_VSS inh_VSSIOR
    M6 (inh_VSS inh_VDDIOR inh_VDDIOR inh_VDDIOR) g45p2svt w=(560u) l=200n nf=56 m=(1)
ends IORINGVSS

// giolib045/BONDPAD52/schematic
subckt BONDPAD52 PAD
ends BONDPAD52
// giolib045/PADVSS/schematic

simulator lang=spectre

subckt PADVSS VSSIOR! VSS VDD VDDIOR!
I0 (VDD VDDIOR! VSS VSSIOR!) IORINGVSS
I1 (VSS) BONDPAD52
ends PADVSS

// giolib045/BONDPAD52/schematic
subckt BONDPAD52 PAD
ends BONDPAD52

// giolib045/IORINGVSS25/schematic
subckt IORINGVSS25 inh_VDD inh_VDDIOR inh_VSS inh_VSS25 inh_VSSIOR
    M6 (inh_VSS25 inh_VDDIOR inh_VDDIOR inh_VDDIOR) g45p2svt w=(560u) l=200n nf=56 m=(1)
ends IORINGVSS25
// giolib045/PADVSS25/schematic

simulator lang=spectre

subckt PADVSS25 VSSIOR! VSS VDDIOR! VSS25! VDD
I1 (VSS25!) BONDPAD52
I0 (VDD VDDIOR! VSS VSS25! VSSIOR!) IORINGVSS25
ends PADVSS25

// giolib045/BONDPAD52/schematic
subckt BONDPAD52 PAD
ends BONDPAD52

// giolib045/IORINGVSSIOR/schematic
subckt IORINGVSSIOR inh_VDD inh_VDDIOR inh_VSS inh_VSSIOR
    M6 (inh_VSSIOR inh_VDDIOR inh_VDDIOR inh_VDDIOR) g45p2svt w=(560u) l=200n nf=56 m=(1)
ends IORINGVSSIOR
// giolib045/PADVSSIOR/schematic

simulator lang=spectre

subckt PADVSSIOR VDD VDDIOR! VSS VSSIOR!
I1 (VSSIOR!) BONDPAD52
I0 (VDD VDDIOR! VSS VSSIOR!) IORINGVSSIOR
ends PADVSSIOR
