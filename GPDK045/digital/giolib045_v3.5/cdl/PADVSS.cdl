************************************************************************
* auCdl Netlist:
*
* Library Name:  giolib045
* Top Cell Name: PADVSS
* View Name:     schematic
* Netlisted on:  Mar 15 07:45:10 2012
************************************************************************

*.BIPOLAR
*.RESI = 2000
*.RESVAL
*.CAPVAL
*.DIOPERI
*.DIOAREA
*.EQUATION
*.SCALE METER
*.MEGA
.PARAM

*.GLOBAL VSSIOR!
+        VSS!
+        VDD!
+        VDDIOR!

*.PIN VSSIOR!
*+    VSS!
*+    VDD!
*+    VDDIOR!

************************************************************************
* Library Name: giolib045
* Cell Name:    IORINGVSS
* View Name:    schematic
************************************************************************

.SUBCKT IORINGVSS inh_VDD inh_VDDIOR inh_VSS inh_VSSIOR
*.PININFO inh_VDD:I inh_VDDIOR:I inh_VSS:I inh_VSSIOR:I
MM6 inh_VSS inh_VDDIOR inh_VDDIOR inh_VDDIOR g45p2svt m=1 l=200n w=560u
.ENDS

************************************************************************
* Library Name: giolib045
* Cell Name:    BONDPAD52
* View Name:    schematic
************************************************************************

.SUBCKT BONDPAD52 PAD
*.PININFO PAD:B
.ENDS

************************************************************************
* Library Name: giolib045
* Cell Name:    PADVSS
* View Name:    schematic
************************************************************************

.SUBCKT PADVSS
*.PININFO
XI0 VDD! VDDIOR! VSS! VSSIOR! / IORINGVSS
XI1 VSS! / BONDPAD52
.ENDS
