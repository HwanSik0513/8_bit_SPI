************************************************************************
* auCdl Netlist:
*
* Library Name:  giolib045
* Top Cell Name: PADVSSIOR
* View Name:     schematic
* Netlisted on:  Mar 15 07:47:28 2012
************************************************************************

*.BIPOLAR
*.RESI = 2000
*.RESVAL
*.CAPVAL
*.DIOPERI
*.DIOAREA
*.EQUATION
*.SCALE METER
*.MEGA
.PARAM

*.GLOBAL VDD!
+        VDDIOR!
+        VSS!
+        VSSIOR!

*.PIN VDD!
*+    VDDIOR!
*+    VSS!
*+    VSSIOR!

************************************************************************
* Library Name: giolib045
* Cell Name:    BONDPAD52
* View Name:    schematic
************************************************************************

.SUBCKT BONDPAD52 PAD
*.PININFO PAD:B
.ENDS

************************************************************************
* Library Name: giolib045
* Cell Name:    IORINGVSSIOR
* View Name:    schematic
************************************************************************

.SUBCKT IORINGVSSIOR inh_VDD inh_VDDIOR inh_VSS inh_VSSIOR
*.PININFO inh_VDD:I inh_VDDIOR:I inh_VSS:I inh_VSSIOR:I
MM6 inh_VSSIOR inh_VDDIOR inh_VDDIOR inh_VDDIOR g45p2svt m=1 l=200n w=560u
.ENDS

************************************************************************
* Library Name: giolib045
* Cell Name:    PADVSSIOR
* View Name:    schematic
************************************************************************

.SUBCKT PADVSSIOR
*.PININFO
XI1 VSSIOR! / BONDPAD52
XI0 VDD! VDDIOR! VSS! VSSIOR! / IORINGVSSIOR
.ENDS
