************************************************************************
* auCdl Netlist:
*
* Library Name:  giolib045
* Top Cell Name: PADVDD
* View Name:     schematic
* Netlisted on:  Mar 15 07:41:41 2012
************************************************************************

*.BIPOLAR
*.RESI = 2000
*.RESVAL
*.CAPVAL
*.DIOPERI
*.DIOAREA
*.EQUATION
*.SCALE METER
*.MEGA
.PARAM

*.GLOBAL VDD!
+        VDDIOR!
+        VSSIOR!
+        VSS!

*.PIN VDD!
*+    VDDIOR!
*+    VSSIOR!
*+    VSS!

************************************************************************
* Library Name: giolib045
* Cell Name:    BONDPAD52
* View Name:    schematic
************************************************************************

.SUBCKT BONDPAD52 PAD
*.PININFO PAD:B
.ENDS

************************************************************************
* Library Name: giolib045
* Cell Name:    IORINGVDD
* View Name:    schematic
************************************************************************

.SUBCKT IORINGVDD inh_VDD inh_VDDIOR inh_VSS inh_VSSIOR
*.PININFO inh_VDD:I inh_VDDIOR:I inh_VSS:I inh_VSSIOR:I
MM4 inh_VDD inh_VSSIOR inh_VSSIOR inh_VSSIOR g45n2svt m=1 l=200n w=560u
.ENDS

************************************************************************
* Library Name: giolib045
* Cell Name:    PADVDD
* View Name:    schematic
************************************************************************

.SUBCKT PADVDD
*.PININFO
XI2 VDD! / BONDPAD52
XI1 VDD! VDDIOR! VSS! VSSIOR! / IORINGVDD
.ENDS
