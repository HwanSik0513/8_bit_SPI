************************************************************************
* auCdl Netlist:
*
* Library Name:  giolib045
* Top Cell Name: PADVDDIOR
* View Name:     schematic
* Netlisted on:  Mar 15 07:44:03 2012
************************************************************************

*.BIPOLAR
*.RESI = 2000
*.RESVAL
*.CAPVAL
*.DIOPERI
*.DIOAREA
*.EQUATION
*.SCALE METER
*.MEGA
.PARAM

*.GLOBAL VDDIOR!
+        VSSIOR!
+        VDD!
+        VSS!

*.PIN VDDIOR!
*+    VSSIOR!
*+    VDD!
*+    VSS!

************************************************************************
* Library Name: giolib045
* Cell Name:    BONDPAD52
* View Name:    schematic
************************************************************************

.SUBCKT BONDPAD52 PAD
*.PININFO PAD:B
.ENDS

************************************************************************
* Library Name: giolib045
* Cell Name:    IORINGVDDIOR
* View Name:    schematic
************************************************************************

.SUBCKT IORINGVDDIOR inh_VDD inh_VDDIOR inh_VSS inh_VSSIOR
*.PININFO inh_VDD:I inh_VDDIOR:I inh_VSS:I inh_VSSIOR:I
MM4 inh_VDDIOR inh_VSSIOR inh_VSSIOR inh_VSSIOR g45n2svt m=1 l=200n w=560u
.ENDS

************************************************************************
* Library Name: giolib045
* Cell Name:    PADVDDIOR
* View Name:    schematic
************************************************************************

.SUBCKT PADVDDIOR
*.PININFO
XI2 VDDIOR! / BONDPAD52
XI0 VDD! VDDIOR! VSS! VSSIOR! / IORINGVDDIOR
.ENDS
