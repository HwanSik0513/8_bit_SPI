// Verilog-AMS netlist generated by the AMS netlister, version  IC6.1.6-64b.500.6 .
// Cadence Design Systems, Inc.

`include "disciplines.vams"

(* cds_ams_schematic *)
module IORINGDO ( .VSSIOR(\VSSIOR! ),.VDDIOR(
\VDDIOR! ),.VDD(\VDD! ),A,PAD,.VSS(\VSS! ) );

input  (*
integer inh_conn_prop_name = "VSSIOR";
integer
inh_conn_def_value = "cds_globals.\\VSSIOR! ";
 *)
 \VSSIOR! ;
input
(*
integer inh_conn_prop_name = "VDDIOR";
integer inh_conn_def_value
 = "cds_globals.\\VDDIOR! ";
 *)
 \VDDIOR! ;
input  (*
integer
inh_conn_prop_name = "VDD";
integer inh_conn_def_value
 = "cds_globals.\\VDD! ";
 *)
 \VDD! ;
input   A;
output   PAD;

input  (*
integer inh_conn_prop_name = "VSS";
integer
inh_conn_def_value = "cds_globals.\\VSS! ";
 *)
 \VSS! ;

levelup_latch (*
integer library_binding = "giolib045";
 *)
I2 ( .\pmos (
\pmos  ), .pmos25( pmos25 ), .nmos25( nmos25 ), .\nmos ( \nmos  ) );

ESDCore04 (*
integer library_binding = "giolib045";
 *)
I3 ( .PMos(
pmos25 ), .PAD( PAD ), .NMos( nmos25 ) );

nonzoutlogic (*
integer library_binding = "giolib045";
 *)
I1 ( .NMOS(
\nmos  ), .A( A ), .PMOS( \pmos  ) );

endmodule
