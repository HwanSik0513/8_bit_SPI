//Verilog-AMS HDL for "giolib045", "PADVSS" "verilogams"

`include "constants.vams"
`include "disciplines.vams"

module PADVSS ( );

endmodule
