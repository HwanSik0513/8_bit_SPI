//Verilog-AMS HDL for "giolib045", "PADVSSIOR" "verilogams"

`include "constants.vams"
`include "disciplines.vams"

module PADVSSIOR ( );

endmodule
