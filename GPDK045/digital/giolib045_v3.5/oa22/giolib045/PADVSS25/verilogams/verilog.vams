//Verilog-AMS HDL for "giolib045", "PADVSS25" "verilogams"

`include "constants.vams"
`include "disciplines.vams"

module PADVSS25 ( );

endmodule
