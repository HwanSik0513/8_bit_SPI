ADE simulation setup
Run mode: Single Run, Sweeps and Corners
Tests:
  giolib045:test_pads:1: giolib045/test_pads/config_extracted, simulator spectre
Global variables:
  vdd = 1.0
  vddior = 2.5
Single Run, Sweeps and Corners options: submitpointsenabled=0
