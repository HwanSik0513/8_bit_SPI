// Verilog-AMS netlist generated by the AMS netlister, version  ICADV12.2-64b.6 .
// Cadence Design Systems, Inc.

`include "disciplines.vams"

(* cds_ams_schematic *)
module test_pads ( rxqclk,vcocaldone,refclk_n,
atb_m,startrccal,scan_in,dvdd,txiclk,SV_n,plllock,SCLK,scan_en,refclk,
rxiclk,dgnd,SSO,startvcocal,rccaldone,agnd_h,rst_n,SSI,atb_p,txqclk,
avdd_h,pmc,scan_out,scan_clk,test_mode,en );

output   rxqclk;
output   vcocaldone;
input   refclk_n;
inout
 atb_m;
input   startrccal;
input [1:0]  scan_in;
input   dvdd;

output   txiclk;
input   SV_n;
output   plllock;
input   SCLK;
input
 scan_en;
input   refclk;
output   rxiclk;
input   dgnd;
output
 SSO;
input   startvcocal;
output   rccaldone;
input   agnd_h;
input
 rst_n;
input   SSI;
inout   atb_p;
output   txqclk;
input   avdd_h;

input   pmc;
output [1:0]  scan_out;
input   scan_clk;
input
 test_mode;
input   en;

padIORINGCORNER (*
integer library_binding = "giolib045";
 *)

u_corner4 ( .VSSIOR( agnd_h ), .VDDIOR( avdd_h ), .VDD( dvdd ), .VSS(
dgnd ) );
padIORINGCORNER (*
integer library_binding = "giolib045";
 *)

u_corner3 ( .VSSIOR( agnd_h ), .VDDIOR( avdd_h ), .VDD( dvdd ), .VSS(
dgnd ) );
padIORINGCORNER (*
integer library_binding = "giolib045";
 *)

u_corner2 ( .VSSIOR( agnd_h ), .VDDIOR( avdd_h ), .VDD( dvdd ), .VSS(
dgnd ) );
padIORINGCORNER (*
integer library_binding = "giolib045";
 *)

u_corner1 ( .VSSIOR( agnd_h ), .VDDIOR( avdd_h ), .VDD( dvdd ), .VSS(
dgnd ) );

PADVSSIOR (*
integer library_binding = "giolib045";
 *)
u_pad_agnd_h
 ( .VSSIOR( agnd_h ), .VDDIOR( avdd_h ), .VDD( dvdd ), .VSS( dgnd ) );

PADDI (*
integer library_binding = "giolib045";
 *)
u_pad_scan_clk ( .VSSIOR(
agnd_h ), .Y( net70 ), .VDD( dvdd ), .VDDIOR( avdd_h ), .PAD( scan_clk ),
.VSS( dgnd ) );
PADDI (*
integer library_binding = "giolib045";
 *)
u_pad_scan_en ( .VSSIOR(
agnd_h ), .Y( net71 ), .VDD( dvdd ), .VDDIOR( avdd_h ), .PAD( scan_en ),
.VSS( dgnd ) );
PADDI (*
integer library_binding = "giolib045";
 *)
u_pad_rst_n ( .VSSIOR(
agnd_h ), .Y( net72 ), .VDD( dvdd ), .VDDIOR( avdd_h ), .PAD( rst_n ),
.VSS( dgnd ) );
PADDI (*
integer library_binding = "giolib045";
 *)
u_pad_startrccal
 ( .VSSIOR( agnd_h ), .Y( net73 ), .VDD( dvdd ), .VDDIOR( avdd_h ), .PAD(
startrccal ), .VSS( dgnd ) );
PADDI (*
integer library_binding = "giolib045";
 *)
u_pad_refclk ( .VSSIOR(
agnd_h ), .Y( net74 ), .VDD( dvdd ), .VDDIOR( avdd_h ), .PAD( refclk ),
.VSS( dgnd ) );
PADDI (*
integer library_binding = "giolib045";
integer
elaboration_binding = "u_pad_scan_in[1]";
 *)
u_pad_scan_in_1 ( .VSSIOR(
agnd_h ), .Y( net75 ), .VDD( dvdd ), .VDDIOR( avdd_h ), .PAD(
scan_in[1] ), .VSS( dgnd ) );
PADDI (*
integer library_binding = "giolib045";
 *)
u_pad_test_mode (
.VSSIOR( agnd_h ), .Y( net76 ), .VDD( dvdd ), .VDDIOR( avdd_h ), .PAD(
test_mode ), .VSS( dgnd ) );
PADDI (*
integer library_binding = "giolib045";
 *)
u_pad_SSI ( .VSSIOR(
agnd_h ), .Y( net77 ), .VDD( dvdd ), .VDDIOR( avdd_h ), .PAD( SSI ), .VSS(
dgnd ) );
PADDI (*
integer library_binding = "giolib045";
 *)
u_pad_SCLK ( .VSSIOR(
agnd_h ), .Y( net78 ), .VDD( dvdd ), .VDDIOR( avdd_h ), .PAD( SCLK ),
.VSS( dgnd ) );
PADDI (*
integer library_binding = "giolib045";
 *)
u_pad_pmc ( .VSSIOR(
agnd_h ), .Y( net79 ), .VDD( dvdd ), .VDDIOR( avdd_h ), .PAD( pmc ), .VSS(
dgnd ) );
PADDI (*
integer library_binding = "giolib045";
integer
elaboration_binding = "u_pad_scan_in[0]";
 *)
u_pad_scan_in_0 ( .VSSIOR(
agnd_h ), .Y( net80 ), .VDD( dvdd ), .VDDIOR( avdd_h ), .PAD(
scan_in[0] ), .VSS( dgnd ) );
PADDI (*
integer library_binding = "giolib045";
 *)
u_pad_refclk_n ( .VSSIOR(
agnd_h ), .Y( net81 ), .VDD( dvdd ), .VDDIOR( avdd_h ), .PAD( refclk_n ),
.VSS( dgnd ) );
PADDI (*
integer library_binding = "giolib045";
 *)
u_pad_SV_n ( .VSSIOR(
agnd_h ), .Y( net82 ), .VDD( dvdd ), .VDDIOR( avdd_h ), .PAD( SV_n ),
.VSS( dgnd ) );
PADDI (*
integer library_binding = "giolib045";
 *)
u_pad_startvcocal
 ( .VSSIOR( agnd_h ), .Y( net83 ), .VDD( dvdd ), .VDDIOR( avdd_h ), .PAD(
startvcocal ), .VSS( dgnd ) );
PADDI (*
integer library_binding = "giolib045";
 *)
u_pad_en ( .VSSIOR(
agnd_h ), .Y( net84 ), .VDD( dvdd ), .VDDIOR( avdd_h ), .PAD( en ), .VSS(
dgnd ) );

PADVDD (*
integer library_binding = "giolib045";
 *)
u_pad_dvdd ( .VSSIOR(
agnd_h ), .VDDIOR( avdd_h ), .VDD( dvdd ), .VSS( dgnd ) );

PADVSS (*
integer library_binding = "giolib045";
 *)
u_pad_dgnd ( .VSSIOR(
agnd_h ), .VDDIOR( avdd_h ), .VDD( dvdd ), .VSS( dgnd ) );

PADDO (*
integer library_binding = "giolib045";
 *)
u_pad_SSO ( .VSSIOR(
agnd_h ), .VDD( dvdd ), .VDDIOR( avdd_h ), .A( net85 ), .PAD( SSO ), .VSS(
dgnd ) );
PADDO (*
integer library_binding = "giolib045";
integer
elaboration_binding = "u_pad_scan_out[1]";
 *)
u_pad_scan_out_1 ( .VSSIOR(
agnd_h ), .VDD( dvdd ), .VDDIOR( avdd_h ), .A( net86 ), .PAD(
scan_out[1] ), .VSS( dgnd ) );
PADDO (*
integer library_binding = "giolib045";
integer
elaboration_binding = "u_pad_scan_out[0]";
 *)
u_pad_scan_out_0 ( .VSSIOR(
agnd_h ), .VDD( dvdd ), .VDDIOR( avdd_h ), .A( net87 ), .PAD(
scan_out[0] ), .VSS( dgnd ) );
PADDO (*
integer library_binding = "giolib045";
 *)
u_pad_vcocaldone
 ( .VSSIOR( agnd_h ), .VDD( dvdd ), .VDDIOR( avdd_h ), .A( net88 ), .PAD(
vcocaldone ), .VSS( dgnd ) );
PADDO (*
integer library_binding = "giolib045";
 *)
u_pad_plllock ( .VSSIOR(
agnd_h ), .VDD( dvdd ), .VDDIOR( avdd_h ), .A( net89 ), .PAD( plllock ),
.VSS( dgnd ) );
PADDO (*
integer library_binding = "giolib045";
 *)
u_pad_rccaldone (
.VSSIOR( agnd_h ), .VDD( dvdd ), .VDDIOR( avdd_h ), .A( net90 ), .PAD(
rccaldone ), .VSS( dgnd ) );

PADANALOG (*
integer library_binding = "giolib045";
 *)
u_pad_txqclk
 ( .VSSIOR( agnd_h ), .VDD( dvdd ), .VDDIOR( avdd_h ), .AY( txqclk ),
.VSS( dgnd ) );
PADANALOG (*
integer library_binding = "giolib045";
 *)
u_pad_txiclk
 ( .VSSIOR( agnd_h ), .VDD( dvdd ), .VDDIOR( avdd_h ), .AY( txiclk ),
.VSS( dgnd ) );
PADANALOG (*
integer library_binding = "giolib045";
 *)
u_pad_rxiclk
 ( .VSSIOR( agnd_h ), .VDD( dvdd ), .VDDIOR( avdd_h ), .AY( rxiclk ),
.VSS( dgnd ) );
PADANALOG (*
integer library_binding = "giolib045";
 *)
u_pad_rxqclk
 ( .VSSIOR( agnd_h ), .VDD( dvdd ), .VDDIOR( avdd_h ), .AY( rxqclk ),
.VSS( dgnd ) );
PADANALOG (*
integer library_binding = "giolib045";
 *)
u_pad_atb_m (
.VSSIOR( agnd_h ), .VDD( dvdd ), .VDDIOR( avdd_h ), .AY( atb_m ), .VSS(
dgnd ) );
PADANALOG (*
integer library_binding = "giolib045";
 *)
u_pad_atb_p (
.VSSIOR( agnd_h ), .VDD( dvdd ), .VDDIOR( avdd_h ), .AY( atb_p ), .VSS(
dgnd ) );

PADVDDIOR (*
integer library_binding = "giolib045";
 *)
u_pad_avdd_h
 ( .VSSIOR( agnd_h ), .VDDIOR( avdd_h ), .VDD( dvdd ), .VSS( dgnd ) );

endmodule
