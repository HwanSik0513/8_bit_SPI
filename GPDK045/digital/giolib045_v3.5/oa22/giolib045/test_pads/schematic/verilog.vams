// Verilog-AMS netlist generated by the AMS netlister, version  IC6.1.5.500.8 .
// Cadence Design Systems, Inc.

`include "disciplines.vams"

(* cds_ams_schematic *)
module test_pads (  );

PADDI (*
integer library_binding = "giolib045";
 *)
I0 ( .Y( paddi ),
.PAD( dOutSide ) );

PADDB (*
integer library_binding = "giolib045";
 *)
I14 ( .Y( paddbY2 ),
.A( dCore ), .PAD( paddb ), .OEN( OEN ) );
PADDB (*
integer library_binding = "giolib045";
 *)
I1 ( .Y( paddbY ),
.A( paddbA ), .PAD( dOutSide ), .OEN( OEN ) );

PADDO (*
integer library_binding = "giolib045";
 *)
I2 ( .A( dCore ),
.PAD( paddo ) );

PADDOZ (*
integer library_binding = "giolib045";
 *)
I3 ( .A( dCore ),
.PAD( paddoz ), .OEN( OEN ) );

resistor #(.r(500K)) (*
integer library_binding = "analogLib";
 *)
R8
 ( paddbY2, cds_globals.\gnd!  );
resistor #(.r(500K)) (*
integer library_binding = "analogLib";
 *)
R7
 ( paddbY, cds_globals.\gnd!  );
resistor #(.r(500K)) (*
integer library_binding = "analogLib";
 *)
R6
 ( paddi, cds_globals.\gnd!  );
resistor #(.r(500K)) (*
integer library_binding = "analogLib";
 *)
R5
 ( paddo, cds_globals.\gnd!  );
resistor #(.r(500K)) (*
integer library_binding = "analogLib";
 *)
R0
 ( paddoz, cds_globals.\gnd!  );

capacitor #(.c(1f)) (*
integer library_binding = "analogLib";
 *)
C7
 ( paddbY2, cds_globals.\gnd!  );
capacitor #(.c(1f)) (*
integer library_binding = "analogLib";
 *)
C6
 ( paddbY, cds_globals.\gnd!  );
capacitor #(.c(1f)) (*
integer library_binding = "analogLib";
 *)
C5
 ( paddi, cds_globals.\gnd!  );
capacitor #(.c(1f)) (*
integer library_binding = "analogLib";
 *)
C4
 ( paddo, cds_globals.\gnd!  );
capacitor #(.c(1f)) (*
integer library_binding = "analogLib";
 *)
C0
 ( paddoz, cds_globals.\gnd!  );

vsource #(.val0(0), .val1(1), .delay(1n), .type("pulse"), .fall(100.0p),
 .width(65n), .rise(100.0p), .period(130n)) (*
integer library_binding
 = "analogLib";
 *)
V4 ( paddbA, cds_globals.\gnd!  );
vsource #(.val0(0), .val1(cds_globals.vddior), .delay(1n), .type("pulse"),
 .fall(100.0p), .width(2.4n), .rise(100.0p), .period(5n)) (*
integer
library_binding = "analogLib";
 *)
V2 ( dOutSide, cds_globals.\gnd!  );
vsource #(.val0(0), .val1(1), .delay(1n), .type("pulse"), .fall(100.0p),
 .width(32n), .rise(100.0p), .period(64n)) (*
integer library_binding
 = "analogLib";
 *)
V1 ( OEN, cds_globals.\gnd!  );
vsource #(.val0(0), .val1(1), .delay(1n), .type("pulse"), .fall(100.0p),
 .width(2.4n), .rise(100.0p), .period(5n)) (*
integer library_binding
 = "analogLib";
 *)
V0 ( dCore, cds_globals.\gnd!  );

vsource #(.type("dc"), .dc(0)) (*
integer library_binding
 = "analogLib";
 *)
V7 ( cds_globals.\VSS! , cds_globals.\gnd!  );
vsource #(.type("dc"), .dc(0)) (*
integer library_binding
 = "analogLib";
 *)
V6 ( cds_globals.\VSSIOR! , cds_globals.\gnd!  );
vsource #(.type("dc"), .dc(cds_globals.vddior)) (*
integer
library_binding = "analogLib";
 *)
V5 ( cds_globals.\VDDIOR! ,
cds_globals.\gnd!  );
vsource #(.type("dc"), .dc(cds_globals.vdd)) (*
integer
library_binding = "analogLib";
 *)
V3 ( cds_globals.\VDD! ,
cds_globals.\gnd!  );

endmodule
