// Verilog-AMS netlist generated by the AMS netlister, version  IC6.1.6-64b.500.6 .
// Cadence Design Systems, Inc.

`include "disciplines.vams"

(* cds_ams_schematic *)
module IORINGDI ( .VSSIOR(\VSSIOR! ),Y,.VDDIOR(
\VDDIOR! ),.VDD(\VDD! ),PAD,.VSS(\VSS! ) );

input  (*
integer inh_conn_prop_name = "VSSIOR";
integer
inh_conn_def_value = "cds_globals.\\VSSIOR! ";
 *)
 \VSSIOR! ;

output   Y;
input  (*
integer inh_conn_prop_name = "VDDIOR";
integer
inh_conn_def_value = "cds_globals.\\VDDIOR! ";
 *)
 \VDDIOR! ;
input
(*
integer inh_conn_prop_name = "VDD";
integer inh_conn_def_value
 = "cds_globals.\\VDD! ";
 *)
 \VDD! ;
input   PAD;
input  (*
integer
inh_conn_prop_name = "VSS";
integer inh_conn_def_value
 = "cds_globals.\\VSS! ";
 *)
 \VSS! ;

inputlogic (*
integer library_binding = "giolib045";
 *)
I2 ( .Y( Y ),
.PAD( PAD ) );

ESDCore04_Input (*
integer library_binding = "giolib045";
 *)
I1 ( .VSSIOR(
\VSSIOR!  ), .VDDIOR( \VDDIOR!  ), .PAD( PAD ) );

endmodule
