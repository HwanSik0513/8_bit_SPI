// Verilog-AMS netlist generated by the AMS netlister, version  IC6.1.5.500.5 .
// Cadence Design Systems, Inc.

`include "disciplines.vams"

(* cds_ams_schematic *)
module PADVDDIOR ( .VSSIOR(\VSSIOR! ),.VDDIOR(
\VDDIOR! ),.VDD(\VDD! ),.VSS(\VSS! ) );

input  (*
integer inh_conn_prop_name = "VSSIOR";
integer
inh_conn_def_value = "cds_globals.\\VSSIOR! ";
 *)
 \VSSIOR! ;
input
(*
integer inh_conn_prop_name = "VDDIOR";
integer inh_conn_def_value
 = "cds_globals.\\VDDIOR! ";
 *)
 \VDDIOR! ;
input  (*
integer
inh_conn_prop_name = "VDD";
integer inh_conn_def_value
 = "cds_globals.\\VDD! ";
 *)
 \VDD! ;
input  (*
integer
inh_conn_prop_name = "VSS";
integer inh_conn_def_value
 = "cds_globals.\\VSS! ";
 *)
 \VSS! ;

BONDPAD52 (*
integer library_binding = "giolib045";
 *)
I2 ( .PAD(
\VDDIOR!  ) );

IORINGVDDIOR (*
integer library_binding = "giolib045";
 *)
I0 ( .VSSIOR(
\VSSIOR!  ), .VDD( \VDD!  ), .VDDIOR( \VDDIOR!  ), .VSS( \VSS!  ) );

endmodule
