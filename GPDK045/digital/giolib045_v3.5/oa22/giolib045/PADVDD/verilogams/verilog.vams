//Verilog-AMS HDL for "giolib045", "PADVDD" "verilogams"

`include "constants.vams"
`include "disciplines.vams"

module PADVDD ( );

endmodule
