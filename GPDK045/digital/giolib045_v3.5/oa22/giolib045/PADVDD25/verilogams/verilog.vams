//Verilog-AMS HDL for "giolib045", "PADVDD25" "verilogams"

`include "constants.vams"
`include "disciplines.vams"

module PADVDD25 ( );

endmodule
