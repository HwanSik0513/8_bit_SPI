//Verilog-AMS HDL for "giolib045", "PADANALOG" "verilogams"

`include "constants.vams"
`include "disciplines.vams"

module PADANALOG ( AY );

  inout AY;

endmodule
