// Verilog-AMS netlist generated by the AMS netlister, version  IC6.1.5.500.9 .
// Cadence Design Systems, Inc.

`include "disciplines.vams"

(* cds_ams_schematic *)
module PADANALOG ( .VSSIOR(\VSSIOR! ),.VDD(
\VDD! ),.VDDIOR(\VDDIOR! ),AY,.VSS(\VSS! ) );

input  (*
integer inh_conn_prop_name = "VSSIOR";
integer
inh_conn_def_value = "cds_globals.\\VSSIOR! ";
 *)
 \VSSIOR! ;
input
(*
integer inh_conn_prop_name = "VDD";
integer inh_conn_def_value
 = "cds_globals.\\VDD! ";
 *)
 \VDD! ;
input  (*
integer
inh_conn_prop_name = "VDDIOR";
integer inh_conn_def_value
 = "cds_globals.\\VDDIOR! ";
 *)
 \VDDIOR! ;
inout   AY;
input  (*

integer inh_conn_prop_name = "VSS";
integer inh_conn_def_value
 = "cds_globals.\\VSS! ";
 *)
 \VSS! ;

BONDPAD52 (*
integer library_binding = "giolib045";
 *)
I1 ( .PAD( AY ) );

g45n2svt #(.ad(56p), .nrd(178.571u), .sca(26.54226), .pd(571.2u), .scc(0.00222),
 .scb(0.03127), .as(57p), .nrs(181.76u), .m(1), .ps(591.4u), .w(560u),
 .sa(150n), .sb(150n), .nf(56), .sd(200n), .l(200n)) (*
integer
library_binding = "gpdk045";
integer passed_mfactor = "m";
 *)
M4 ( AY,
\VSSIOR! , \VSSIOR! , \VSSIOR!  );

endmodule
